# Ansys Electronics Desktop project, version 2021.1
materials:
  vacuum: permittivity=1
  copper: permeability=0.999991 conductivity=58000000
  sapphire: permittivity=10

design qubit_Q3D (Q3D Extractor, model units mm)
options: SParamCalcMethod=EqTransLine Calculate_Lossy_Dielectrics
variables:
  Stock_L = -2in
  Stock_W = 0.625in
  Stock_H = 2.25in
  Cav_width = 0.188in
  Q_hole_len = (((Stock_W) - (Cav_width)) / (2)) + ((Cav_width) / (2))
  Q_hole_dia = 0.125in
  Q_hole_loc_x = (Stock_L) / (2)
  Q_hole_loc_y = Stock_W
  Q_hole_loc_z = (Stock_H) / (2)
  Q_chip_y_offset = -0.05in
  Chip_W = 2.9mm
  Chip_L = 10mm
  Chip_H = 0.4mm
  Q_chip_loc_x = Q_hole_loc_x
  Q_chip_loc_y = (((Stock_W) / (2)) + ((Chip_L) / (2))) + (Q_chip_y_offset)
  Q_chip_loc_z = Q_hole_loc_z
  pad_y_offset = 0.5mm
  pad_l = 0.8mm
  pad_w = 350um
  pad_gap = 100um
  pad_x = (Q_chip_loc_x) - ((pad_w) / (2))
  pad_y = ((Q_chip_loc_y) + (pad_y_offset)) - ((Chip_L) / (2))
  pad_z = (Q_chip_loc_z) + ((Chip_H) / (2))
  jj_w = 50um
  pad_y_2 = ((pad_y) + (pad_l)) + (pad_gap)
  junc_y = (pad_y) + (pad_l)
  junc_x = (pad_x) + (((pad_w) - (jj_w)) / (2))
  pad_t = 50nm
geometry:
  Solid1 = imported_body(C:\_Lib\python\Automated-RF-Design\3D Cavity Demonstrations\Inventor Files\\00002_single_mode_flute.stp)
  Box1 [Vacuum] = box(corner=(0, 0, 0), size=(Stock_L, Stock_W, Stock_H))
  Box1.subtract(Solid1)
  Q_Hole = cylinder(axis=Y, base_centre=(Q_hole_loc_x, Q_hole_loc_y, Q_hole_loc_z), radius=(Q_hole_dia) / (2), height=-(Q_hole_len))
  Box1.unite(Q_Hole)
  Chip_sub = box(corner=((Q_chip_loc_x) - ((Chip_W) / (2)), (Q_chip_loc_y) - ((Chip_L) / (2)), (Q_chip_loc_z) - ((Chip_H) / (2))), size=(Chip_W, Chip_L, Chip_H))
  Box1.unite(Chip_sub)
  Chip [Sapphire] = box(corner=((Q_chip_loc_x) - ((Chip_W) / (2)), (Q_chip_loc_y) - ((Chip_L) / (2)), (Q_chip_loc_z) - ((Chip_H) / (2))), size=(Chip_W, Chip_L, Chip_H))
  Pad_1 [copper] = rectangle(corner=(pad_x, pad_y, pad_z), x_size=pad_w, y_size=pad_l)
  Pad_2 [copper] = rectangle(corner=(pad_x, pad_y_2, pad_z), x_size=pad_w, y_size=pad_l)
  jj [copper] = rectangle(corner=(junc_x, junc_y, pad_z), x_size=jj_w, y_size=pad_gap)
boundaries and excitations:
  Pad_1_thin_cond: ThinConductor Objects=Pad_1 Material=Copper Thickness=pad_t
  Pad_2_thin_cond: ThinConductor Objects=Pad_2 Material=Copper Thickness=pad_t
  Pad_1_Net: SignalNet Objects=Pad_1
  Pad_2_Net: SignalNet Objects=Pad_2
setups:
  Ec_Test: Matrix AdaptiveFreq=5GHz Cap{MaxPass=10 MinPass=1 MinConvPass=1 PerError=1 PerRefine=30 SolutionOrder=High Solver_Type=Iterative}
source amplitudes:
  Pad_1_Net: Cap 1V 0deg
  Pad_2_Net: Cap 0V 0deg
