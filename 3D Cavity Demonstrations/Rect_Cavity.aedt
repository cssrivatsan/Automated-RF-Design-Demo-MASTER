# Ansys Electronics Desktop project, version 2021.1
materials:
  vacuum: permittivity=1
  copper: permeability=0.999991 conductivity=58000000

design Rect_Cav_EM (HFSS, Eigenmode, model units mm)
geometry:
  Solid1 [vacuum] = imported_body(C:\_Lib\python\Automated-RF-Design\3D Cavity Demonstrations\rect_cavity_vol.stp)
setups:
  Test_EM: HfssEigen MinimumFrequency=1GHz NumModes=2 MaxDeltaFreq=0.1 ConvergeOnRealFreq=true MaximumPasses=10 MinimumPasses=1 MinimumConvergedPasses=3 PercentRefinement=30 BasisOrder=-1
source amplitudes:
  #-10:1: 1 0deg
  #-10:2: 0 0deg
